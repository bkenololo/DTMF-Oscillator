* Extracted from DTMF4.asc and matching hierarchy
XU_LOW.U1A U_LOW.WIEN U_LOW.N1 VCC VEE LOW_OUT TL074
RU_LOW.R6 U_LOW.N2 LOW_OUT 15k
RU_LOW.R7 U_LOW.N1 U_LOW.N2 7.5k
XU_LOW.D1 U_LOW.N1 U_LOW.N2 1N4148
XU_LOW.D2 U_LOW.N2 U_LOW.N1 1N4148
RU_LOW.R5 U_LOW.N1 0 10k
RU_LOW.R1 U_LOW.N3 LOW_OUT 20k
RU_LOW.R2 U_LOW.N4 U_LOW.N3 620
CU_LOW.C1 U_LOW.WIEN U_LOW.N4 10n
RU_LOW.R3 U_LOW.WIEN U_LOW.N5 20k
RU_LOW.R4 U_LOW.N5 0 560
CU_LOW.C2 U_LOW.WIEN 0 10n
IU_LOW.seed 0 U_LOW.WIEN PWL(0 0 1u 0 2u 100n 11u 100n 12u 0)
XU_HIGH.U1B U_HIGH.WIEN U_HIGH.N1 VCC VEE HIGH_OUT TL074
RU_HIGH.R13 U_HIGH.N2 HIGH_OUT 15k
RU_HIGH.R14 U_HIGH.N1 U_HIGH.N2 7.5k
XU_HIGH.D3 U_HIGH.N1 U_HIGH.N2 1N4148
XU_HIGH.D4 U_HIGH.N2 U_HIGH.N1 1N4148
RU_HIGH.R12 U_HIGH.N1 0 10k
RU_HIGH.R8 U_HIGH.N3 HIGH_OUT 13k
RU_HIGH.R9 U_HIGH.N4 U_HIGH.N3 82
CU_HIGH.C3 U_HIGH.WIEN U_HIGH.N4 10n
RU_HIGH.R10 U_HIGH.WIEN U_HIGH.N5 13k
RU_HIGH.R11 U_HIGH.N5 0 110
CU_HIGH.C4 U_HIGH.WIEN 0 10n
IU_HIGH.seed 0 U_HIGH.WIEN PWL(0 0 1u 0 2u 100n 11u 100n 12u 0)
XU_SUM.U1C 0 U_SUM.N1 VCC VEE DTMF_OUT TL074
RU_SUM.R17 U_SUM.N1 DTMF_OUT 10k
RU_SUM.R15 LOW_OUT U_SUM.N1 22k
RU_SUM.R16 HIGH_OUT U_SUM.N1 22k
RRscope DTMF_OUT 0 1Meg
VVpositive VCC 0 12
VVnegative VEE 0 -12
CCdec_pos VCC 0 100n
CCbulk_pos VCC 0 10u
CCdec_neg VEE 0 100n
CCbulk_neg 0 VEE 10u
XU1D 0 N1 VCC VEE N1 TL074
.include "models.inc"
.temp 27
.options reltol=1e-5 abstol=1e-10 vntol=1e-7 method=trap plotwinsize=0
.tran 1.25u 0.5 0 1.25u
.save V(LOW_OUT) V(HIGH_OUT) V(DTMF_OUT)
.meas tran T_low TRIG V(LOW_OUT) VAL=0 RISE=1 TD=0.4 TARG V(LOW_OUT) VAL=0 RISE=2 TD=0.4
.meas tran f_low PARAM 1/T_low
.meas tran vpp_low PP V(LOW_OUT) FROM 0.4 TO 0.5
.meas tran T_high TRIG V(HIGH_OUT) VAL=0 RISE=1 TD=0.4 TARG V(HIGH_OUT) VAL=0 RISE=2 TD=0.4
.meas tran f_high PARAM 1/T_high
.meas tran vpp_high PP V(HIGH_OUT) FROM 0.4 TO 0.5
.meas tran vpp_dtmf PP V(DTMF_OUT) FROM 0.4 TO 0.5
.end
