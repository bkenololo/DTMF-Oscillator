* Extracted from Test_SummingAmplifier.asc and matching hierarchy
XU_TEST.U1C 0 U_TEST.N1 VCC VEE SUM_OUT TL074
RU_TEST.R17 U_TEST.N1 SUM_OUT 10k
RU_TEST.R15 IN_LOW U_TEST.N1 22k
RU_TEST.R16 IN_HIGH U_TEST.N1 22k
VVIN_LOW IN_LOW 0 SINE(0 3 770)
VVIN_HIGH IN_HIGH 0 SINE(0 3 1209)
RRload SUM_OUT 0 1Meg
VVpositive VCC 0 12
VVnegative VEE 0 -12
.include "models.inc"
.temp 27
.options reltol=1e-5 abstol=1e-10 vntol=1e-7 method=trap plotwinsize=0
.tran 1.25u 0.5 0 1.25u
.save V(IN_LOW) V(IN_HIGH) V(SUM_OUT)
.meas tran vpp_sum PP V(SUM_OUT) FROM 0.4 TO 0.5
.end
